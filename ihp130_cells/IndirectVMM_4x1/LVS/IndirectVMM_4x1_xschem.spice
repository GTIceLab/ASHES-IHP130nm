** sch_path: /home/lhanks6/ASHES-IHP130nm/ihp130_cells/IndirectVMM_4x1/IndirectVMM_4x1.sch
.subckt IndirectVMM_4x1 Vd_P[0] Vd_P[1] Vd_P[2] Vd_P[3] Vd_R[0] Vd_R[1] Vd_R[2] Vd_R[3] Vg Vs VTUN Vsel VINJ GND
*.PININFO Vd_R[0:3]:B Vd_P[0:3]:B Vg:B VTUN:B Vsel:B GND:B VINJ:B Vs:B
x1[0] Vs Vg Vsel VTUN Vd_R[0] Vd_P[0] VINJ GND FG_Indirect
x1[1] Vs Vg Vsel VTUN Vd_R[1] Vd_P[1] VINJ GND FG_Indirect
x1[2] Vs Vg Vsel VTUN Vd_R[2] Vd_P[2] VINJ GND FG_Indirect
x1[3] Vs Vg Vsel VTUN Vd_R[3] Vd_P[3] VINJ GND FG_Indirect
.ends

* expanding   symbol:  FG_Indirect/FG_Indirect.sym # of pins=16
** sym_path: /home/lhanks6/ASHES-IHP130nm/ihp130_cells/FG_Indirect/FG_Indirect.sym
** sch_path: /home/lhanks6/ASHES-IHP130nm/ihp130_cells/FG_Indirect/FG_Indirect.sch
.subckt FG_Indirect Vs Vg Vsel VTUN Vd_R Vd_P VINJ GND
*.PININFO VINJ:B Vsel:B Vg:B Vs:B Vd_R:B Vd_P:B VTUN:B GND:B
M4 net1 Vsel VINJ VINJ sg13_hv_pmos w=0.42u l=0.5u ng=1 m=1
M5 Vd_P Vfg net1 VINJ sg13_hv_pmos w=0.42u l=0.5u ng=1 m=1
M1 Vd_R Vfg Vs VINJ sg13_hv_pmos w=0.42u l=0.5u ng=1 m=1
X3 Vfg VTUN Svaricap w=.29u l=.5u
X1 Vfg Vg Svaricap w=.54u l=.65u
.ends
